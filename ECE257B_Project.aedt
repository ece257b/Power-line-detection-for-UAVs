# Ansys Electronics Desktop project, version 2022.1
project variables:
  $y = 0
  $z = 0
materials:
  Arlon DiClad 880 (tm): permittivity=2.2 dielectric_loss_tangent=0.0009
  copper: permeability=0.999991 conductivity=58000000
  vacuum: permittivity=1
  pec: conductivity=1e+30
  Rogers RO4350 (tm): permittivity=3.66 dielectric_loss_tangent=0.004

design Coax_RCS (HFSS, DrivenModal, model units mm)
options: Calculate_Lossy_Dielectrics Save_Adaptive_support_files
variables:
  Dinner = 1.25mm
  len = 60mm
  Douter1 = 4.31mm
  Douter2 = 3.31mm
geometry:
  innerConductor [copper] = cylinder(axis=Z, base_centre=(0mm, 0mm, 0mm), radius=Dinner/2, height=len)
  shieldOuter [copper] = cylinder(axis=Z, base_centre=(0mm, 0mm, 0mm), radius=Douter1/2, height=len)
  dielectricInner [Arlon DiClad 880 (tm)] = cylinder(axis=Z, base_centre=(0mm, 0mm, 0mm), radius=Douter2/2, height=len)
  shieldInner_1 = dielectricInner.copy()
  shieldOuter.subtract(shieldInner_1)
  dielectricInnerConductor = cylinder(axis=Z, base_centre=(0mm, 0mm, 0mm), radius=Dinner/2, height=len)
  dielectricInner.subtract(dielectricInnerConductor)
  radBoundary [vacuum] = cylinder(axis=Z, base_centre=(0mm, 0mm, 0mm), radius=Douter1/2+0.1mm, height=len)
  Port1 = circle(normal=Z, centre=(0mm, 0mm, 0mm), radius=Douter2/2)
  Port2 = circle(normal=Z, centre=(0mm, 0mm, len), radius=Douter2/2)
  Line1 = polyline((Dinner, 0mm, 0mm) (Dinner, 0mm, 60mm))
boundaries and excitations:
  Rad1: Radiation Objects=radBoundary
  IncPWave1: Plane Incident Wave Objects=shieldOuter PhiStart=-180deg PhiStop=180deg PhiPoints=181 ThetaStart=45deg ThetaStop=45deg ThetaPoints=1 EoPhi=0 EoTheta=1 OriginX=0 OriginY=0 OriginZ=len/2 IsPropagating
  z+: Current Faces=innerConductor.face(2 of 3, 3 of 3) Direction{(0, 0, 0) -> (0, 0, 60)}
  z-: Current Faces=shieldOuter.face(2 of 3, 3 of 3) Direction{(0mm, 2000mm, 60000mm) -> (0mm, 2000mm, 0mm)}
setups:
  Setup1: HfssDriven Frequency=24GHz MaxDeltaE=0.02 MaximumPasses=6 MinimumPasses=1 MinimumConvergedPasses=1 PercentRefinement=30 BasisOrder=1 DrivenSolverType="Domain Decomposition" IterativeResidual=1e-06 DDMSolverResidual=0.0001
source amplitudes:
  IncPWave1:1: 1 0deg
  z+:1, z-:1: 0A 0deg
radiation setups:
  Infinite Sphere1: Infinite Sphere Theta=0deg..180deg step 10deg Phi=0deg..360deg step 10deg
field plots:
  Mag_E1: E Field over shieldOuter.face(all 4) on Setup1 : LastAdaptive at Freq=24GHz Phase=0deg
  Mag_E2: E Field over innerConductor.face(all 3) on Setup1 : LastAdaptive at Freq=24GHz Phase=0deg
reports:
  Monostatic RCS Plot: dB(MonostaticRCSTotal) vs IWavePhi on Setup1 : LastAdaptive [IWaveTheta=45deg Freq=24GHz]
  Monostatic RCS polar Plot: dB(MonostaticRCSTotal) vs IWavePhi on Setup1 : LastAdaptive [IWaveTheta=45deg Freq=24GHz]

design Radar_imaging (HFSS, SBR+, model units meter)
variables:
  dx = 10meter
  dy = 0
  dz = 0
  radius = 100mm
  length = 5meter
  center = -2.5
geometry:
  coordinate_system RelativeCS1 = origin=(dx, dy, dz) x=(1meter, 0meter, 0meter) y=(0meter, 1meter, 0meter)
  Tx = component(Beam1, Type="Parametric Beam" Unit=meter Size=0.1meter Sheet=6 MatchedPortImpedance=50ohm Polarization=Vertical Representation="Far Field" Vertical_BeamWidth=30deg Horizontal_BeamWidth=60deg)
  Beam1_Footprint [non-model] = part_of(Tx)
  Rx1 = component(Rx, Type="Parametric Beam" Unit=meter Size=0.1meter Sheet=6 MatchedPortImpedance=50ohm Polarization=Vertical Representation="Far Field" Vertical_BeamWidth=30deg Horizontal_BeamWidth=60deg)
  Rx_Footprint [non-model] = part_of(Rx1)
  Cylinder1 [pec] = cylinder(axis=Y, base_centre=(0meter, center, 0meter), radius=radius, height=length) in RelativeCS1
boundaries and excitations:
  Tx_p1: Proxy Port Objects=Beam1_Footprint DefinitionPortType=-3 NumModes=1 RenormalizeAllTerminals=false Modes{Mode1{CharImp=Zpi}}
  Rx1_p1: Proxy Port Objects=Rx_Footprint DefinitionPortType=-3 NumModes=1 RenormalizeAllTerminals=false Modes{Mode1{CharImp=Zpi}}
setups:
  Setup1: HfssDriven RayDensityPerWavelength=4 MaxNumberOfBounces=5 PTDUTDSimulationSettings=None
    sweep Sweep: 0.1GHz to 35GHz step 0.5GHz;
source amplitudes:
  Tx_p1:1: 1W 0deg
  Rx1_p1:1: 0W 0deg
radiation setups:
  Infinite Sphere1: Infinite Sphere Theta=0deg..180deg step 2deg Phi=-180deg..180deg step 2deg
  Infinite Sphere2: Infinite Sphere Theta=0deg..180deg step 2deg Phi=-180deg..180deg step 2deg
reports:
  S Parameter Plot 1: dB(S(Rx1_p1,Tx_p1)) vs Freq on Setup1 : Sweep [radius=all]
  S Parameter Table 1: re(S(Rx1_p1,Tx_p1)) vs Freq on Setup1 : Sweep [radius=100mm]
  S Parameter Table 2: im(S(Rx1_p1,Tx_p1)) vs Freq on Setup1 : Sweep [radius=100mm]
  S Parameter Table 3: re(S(Rx1_p1,Tx_p1)) vs Freq on Setup1 : Sweep [dy=all dz=all radius=100mm]
  S Parameter Table 4: im(S(Rx1_p1,Tx_p1)) vs Freq on Setup1 : Sweep [dy=all dz=all radius=100mm]
  S Parameter Table 5: re(S(Rx1_p1,Tx_p1)) vs Freq on Setup1 : Sweep [dy=all dz=all radius=1000mm]
  S Parameter Table 6: im(S(Rx1_p1,Tx_p1)) vs Freq on Setup1 : Sweep [dy=all dz=all radius=1000mm]
  S Parameter Table 7: im(S(Rx1_p1,Tx_p1)) vs Freq on Setup1 : Sweep [dy=-1,-0.5,0,0.5,1 dz=-1,-0.5,0,0.5,1 radius=100mm]
  S Parameter Table 8: re(S(Rx1_p1,Tx_p1)) vs Freq on Setup1 : Sweep [dy=-1,-0.5,0,0.5,1 dz=-1,-0.5,0,0.5,1 radius=100mm]
  S Parameter Table 9: im(S(Rx1_p1,Tx_p1)) vs Freq on Setup1 : Sweep [dy=-1,-0.5,0,0.5,1 dz=-1,-0.5,0,0.5,1 radius=100mm]
  S Parameter Table 10: re(S(Rx1_p1,Tx_p1)) vs Freq on Setup1 : Sweep [dy=-1,-0.5,0,0.5,1 dz=-1,-0.5,0,0.5,1 radius=10mm]
  S Parameter Table 11: im(S(Rx1_p1,Tx_p1)) vs Freq on Setup1 : Sweep [dy=-1,-0.5,0,0.5,1 dz=-1,-0.5,0,0.5,1 radius=10mm]
  S Parameter Table 12: re(S(Rx1_p1,Tx_p1)) vs Freq on Setup1 : Sweep [dy=-1,-0.5,0,0.5,1 dz=-1,-0.5,0,0.5,1 radius=1mm]
  S Parameter Table 13: im(S(Rx1_p1,Tx_p1)) vs Freq on Setup1 : Sweep [dy=-1,-0.5,0,0.5,1 dz=-1,-0.5,0,0.5,1 radius=1mm]
  S Parameter plot for 1mm: dB(S(Rx1_p1,Tx_p1)) vs Freq on Setup1 : Sweep [dy=-1,-0.5,0,0.5,1 dz=-1,-0.5,0,0.5,1 radius=1mm]
  S Parameter Plot for 1mm and 10mm: dB(S(Rx1_p1,Tx_p1)) vs Freq on Setup1 : Sweep [dy=-1,-0.5,0,0.5,1 dz=-1,-0.5,0,0.5,1 radius=1mm,10mm]
  S Parameter Plot 2: dB(S(Rx1_p1,Tx_p1)) vs Freq on Setup1 : Sweep [dy=0 dz=0 radius=all length=all]
  S Parameter Plot 3: dB(S(Rx1_p1,Rx1_p1)) vs Freq on Setup1 : Sweep [dy=0 dz=0 radius=all]
  S Parameter Plot 4: dB(S(Rx1_p1,Tx_p1)) vs Freq on Setup1 : Sweep [dy=0 dz=0 radius=all length=5meter]

design SBR_VRT (HFSS, SBR+, model units meter)
variables:
  radius = 0.1meter
  height = 30meter
  len = 60mm
  Dinner = 1.25mm
  Douter2 = 3.31mm
  Douter1 = 4.31mm
geometry:
  coordinate_system Tx = origin=(0meter, $y, $z) x=(1meter, 0meter, 0meter) y=(0meter, 1meter, 0meter)
  coordinate_system Rx = origin=(0meter, 2meter, 0meter) x=(1meter, 0meter, 0meter) y=(0meter, 1meter, 0meter) in Tx
  coordinate_system wire = origin=(20meter, 0meter, 0meter) x=(1meter, 0meter, 0meter) y=(0meter, 1meter, 0meter) in Tx
  Cylinder1 [pec] = cylinder(axis=Y, base_centre=(0meter, 0meter, 0meter), radius=radius, height=height) in wire
  Rx_1 = component(Beam1, Type="Parametric Beam" Unit=meter Size=0.1meter Sheet=6 MatchedPortImpedance=50ohm Polarization=Vertical Representation="Far Field" Vertical_BeamWidth=30deg Horizontal_BeamWidth=60deg)
  Beam1_Footprint [non-model] = part_of(Rx_1) in Rx
  Tx_1 = component(Beam2, Type="Parametric Beam" Unit=meter Size=0.1meter Sheet=6 MatchedPortImpedance=50ohm Polarization=Vertical Representation="Far Field" Vertical_BeamWidth=30deg Horizontal_BeamWidth=60deg)
  Beam2_Footprint [non-model] = part_of(Tx_1) in Tx
boundaries and excitations:
  IncPWave1: Plane Incident Wave Objects=#97 PhiStart=90deg PhiStop=90deg PhiPoints=1 ThetaStart=45deg ThetaStop=45deg ThetaPoints=1 EoPhi=1 EoTheta=0 OriginX=0 OriginY=0 OriginZ=len/2 IsPropagating
  Rx_1_p1: Proxy Port Objects=Beam1_Footprint DefinitionPortType=-3 NumModes=1 RenormalizeAllTerminals=false Modes{Mode1{CharImp=Zpi}}
  Tx_1_p1: Proxy Port Objects=Beam2_Footprint DefinitionPortType=-3 NumModes=1 RenormalizeAllTerminals=false Modes{Mode1{CharImp=Zpi}}
setups:
  Setup1: HfssDriven RayDensityPerWavelength=4 MaxNumberOfBounces=5 IsMonostaticRCS PTDUTDSimulationSettings=None ComputeFarFields
    sweep Sweep: 1GHz to 10GHz step 1GHz;
source amplitudes:
  Rx_1_p1:1: 1W 0deg
  Tx_1_p1:1: 0W 0deg
  IncPWave1:1: 0 0deg
field plots:
  SBR_Plot1: Visual Ray Trace SBR on Setup1 : LastAdaptive

design Horn_antenna (HFSS, DrivenModal, model units mm)
options: Calculate_Lossy_Dielectrics Save_Adaptive_support_files
variables:
  wg_length = 5mm
  b = 9.525mm
  a = 19.05mm
  rr = a/1.5
  sb = 9.525mm
  sa = 14.31mm
  t = 0.5mm
  h_cone = 5.36mm
  hh = 16mm
  r_bottom_cone = 39.5mm
  r_top_cone = 25mm
  th_cone = 0.1mm
  cone_gap = 5mm
  r4 = 45mm
  dist_z = 1mm
  gh = 10mm
  ct = 39.5mm
  cb = rr
  cth = 0.1mm
  h_fl = 80mm
  sa_f = 80mm
  sb_f = 40mm
  arad = sa_f+2*t+4mm
  brad = sb_f+2*t+4mm
  hrad = wg_length+h_fl+1000mm
geometry:
  inner = box(corner=(-a/2, -b/2, 0mm), size=(a, b, wg_length))
  waveguide [copper], Box1_ObjectFromFace2, Box1_ObjectFromFace3, Box1_ObjectFromFace4 = object_from(inner.face(-y, -x, +y, +x))
  inner.delete()
  waveguide.unite(Box1_ObjectFromFace2, Box1_ObjectFromFace3, Box1_ObjectFromFace4)
  waveguide.thicken(t)
  Line_X = polyline((-sa_f/2, 0mm, wg_length+t+h_fl+900mm) (sa_f/2, 0mm, wg_length+t+h_fl+900mm))
  line_Y = polyline((0mm, -sb_f/2, wg_length+t+h_fl+900mm) (0mm, sb_f/2, wg_length+t+h_fl+900mm))
  plate [copper] = rectangle(corner=(-a/2, -b/2, 0), x_size=a, y_size=b)
  plate.thicken(t)
  horn [copper] = rectangle(corner=(-a/2-t, -b/2-t, wg_length), x_size=a+2*t, y_size=b+2*t)
  PyH_front = rectangle(corner=(-sa_f/2-t, -sb_f/2-t, wg_length+h_fl), x_size=sa_f+2*t, y_size=sb_f+2*t)
  horn.connect(PyH_front)
  PyH1 = rectangle(corner=(-a/2, -b/2, wg_length), x_size=a, y_size=b)
  PyH_front1 = rectangle(corner=(-sa_f/2, -sb_f/2, wg_length+h_fl), x_size=sa_f, y_size=sb_f)
  PyH1.connect(PyH_front1)
  horn.subtract(PyH1)
  radbox [vacuum] = box(corner=(-arad/2, -brad/2, 0mm), size=(arad, brad, hrad))
boundaries and excitations:
  Rad1: Radiation Objects=radbox
  1: Wave Port Faces=plate.face(at (0, 0, 0.5)) NumModes=1 Modes{Mode1{IntLine{(0, -4.7625, 0.5) -> (0, 4, 0.5)} CharImp=Zpi}}
setups:
  Setup1: HfssDriven Frequency=24GHz MaxDeltaS=0.02 MaximumPasses=10 MinimumPasses=1 MinimumConvergedPasses=1 PercentRefinement=30 BasisOrder=1 PortAccuracy=2 DrivenSolverType="Direct Solver"
    sweep Sweep: 8GHz to 30GHz step 1GHz; Type=Fast SaveFields
source amplitudes:
  1:1: 1W 0deg
radiation setups:
  Infinite Sphere1: Infinite Sphere Theta=-180deg..180deg step 5deg Phi=0deg..360deg step 5deg

design Patch_antenna (HFSS, DrivenTerminal, model units mm)
variables:
  substrate = 40mm
  h = 31mil
  lp = 7.5mm
  wp = 10mm
  x0 = 2.6mm
  y0 = 2.8mm
  w50 = 1.76mm
  L1 = 2mm
  W = 10mm
  d = 10mm
geometry:
  Substrate [Rogers RO4350 (tm)] = box(corner=(-substrate/2, -substrate/2, 0mm), size=(substrate, substrate, -h))
  Ground_plane = rectangle(corner=(-substrate/2, -substrate/2, -h), x_size=substrate, y_size=substrate)
  Patch = rectangle(corner=(-lp/2, -wp/2, 0mm), x_size=lp, y_size=wp)
  Gap = rectangle(corner=(lp/2-x0, -y0/2, 0mm), x_size=x0, y_size=y0)
  Patch.subtract(Gap)
  Feed_line = rectangle(corner=(lp/2-x0, -w50/2, 0mm), x_size=x0+L1, y_size=w50)
  Patch.unite(Feed_line)
  Source = rectangle(corner=(lp/2+L1, -w50/2, 0mm), y_size=w50, z_size=-h)
  Air [vacuum] = box(corner=(-substrate/2, -substrate/2, 0mm), size=(substrate, substrate, W))
  line [non-model] = polyline((-20mm, 7mm, d) (20mm, 7mm, d))
  coordinate_system RelativeCS1 = origin=(0mm, 0mm, 70mm) x=(1mm, 0mm, 0mm) y=(0mm, 1mm, 0mm)
boundaries and excitations:
  PerfE_ground: Perfect E Objects=Ground_plane
  PerfE_patch: Perfect E Objects=Patch
  Radiation: Radiation Faces=Air.face(+z, -y, -x, +y, +x)
  1: Terminal port=p1 Edges=Patch.edge(2 of 4) TerminalResistance=50ohm
  p1: Lumped Port Faces=Source.face Impedance=50ohm
  reference conductors: Ground_plane
setups:
  Setup1: HfssDriven Frequency=24GHz MaxDeltaS=0.02 MaximumPasses=6 MinimumPasses=1 MinimumConvergedPasses=1 PercentRefinement=30 BasisOrder=1 PortAccuracy=2 DrivenSolverType="Direct Solver"
    sweep Sweep: 8GHz to 12GHz, 21 points; Type=Discrete SaveFields
source amplitudes:
  p1:1: 1V 0deg
radiation setups:
  Infinite Sphere1: Infinite Sphere Theta=0deg..180deg step 10deg Phi=-180deg..180deg step 10deg
field calculator expressions:
  Emag_line = Fundamental_Quantity(0) | Tangent | CmplxR | Dot | CmplxMag
  Ephase_line = Fundamental_Quantity(0) | Tangent | CmplxR | Dot | Phase
  E_mag_line = Fundamental_Quantity(0) | Tangent | CmplxR | Dot | CmplxMag
  E_phase_line = Fundamental_Quantity(0) | Tangent | CmplxR | Dot | Phase

design Coax_Magnetic_field (Maxwell 3D, Magnetostatic, model units mm)
variables:
  Dinner = 1.25mm
  len = 60mm
  Douter2 = 3.31mm
  Douter1 = 4.31mm
  d = 10meter
geometry:
  innerConductor [copper] = cylinder(axis=Z, base_centre=(0mm, 0mm, 0mm), radius=Dinner/2, height=len)
  shieldOuter [copper] = cylinder(axis=Z, base_centre=(0mm, 0mm, 0mm), radius=Douter1/2, height=len)
  dielectricInner [Arlon DiClad 880 (tm)] = cylinder(axis=Z, base_centre=(0mm, 0mm, 0mm), radius=Douter2/2, height=len)
  shieldInner_1 = dielectricInner.copy()
  shieldOuter.subtract(shieldInner_1)
  dielectricInnerConductor = cylinder(axis=Z, base_centre=(0mm, 0mm, 0mm), radius=Dinner/2, height=len)
  dielectricInner.subtract(dielectricInnerConductor)
  radBoundary [vacuum] = cylinder(axis=Z, base_centre=(0mm, 0mm, 0mm), radius=Douter1/2+d, height=len)
  Line1 = polyline((Dinner, 0mm, 0mm) (Dinner, 0mm, 60mm))
boundaries and excitations:
  Current1: Current Faces=innerConductor.face(2 of 3) Current=500mA IsSolid=true Point_out_of_terminal=false
  Current2: Current Faces=shieldOuter.face(3 of 3) Current=500mA IsSolid=true Point_out_of_terminal=false
  Current3: Current Faces=innerConductor.face(3 of 3) Current=500mA IsSolid=true Point_out_of_terminal=true
  Current4: Current Faces=shieldOuter.face(2 of 3) Current=500mA IsSolid=true Point_out_of_terminal=true
mesh:
  initial mesh: GlobalCurvilinear{Apply}
setups:
  Setup1: Magnetostatic MaximumPasses=10 MinimumPasses=2 MinimumConvergedPasses=1 PercentRefinement=30 PercentError=1 NonLinearResidual=0.001
field plots:
  Mag_H1: H in radBoundary on Setup1 : LastAdaptive
  Mag_H2: H over radBoundary.face(1 of 3) on Setup1 : LastAdaptive
